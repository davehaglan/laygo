ADE simulation setup
Run mode: Single Run, Sweeps and Corners
Tests:
  serdes_testbenches:serdes:1: serdes_testbenches/ser/config, simulator spectre
    Outputs: (cross(VT("/clk_div") (VAR("vdd") / 2) 1 "rising" nil nil nil) - cross(VT("/dout<0>") (VAR("vdd") / 2) 1 "rising" nil nil nil)); (cross(VT("/divclk") (VAR("vdd") / 2) 1 "rising" nil nil nil) - cross(VT("/dout<0>") (VAR("vdd") / 2) 1 "rising" nil nil nil)); (cross(VT("/divclk") (VAR("dvdd") / 2) 1 "rising" nil nil nil) - cross(VT("/divclk") (VAR("vdd") / 2) 1 "rising" nil nil nil)); (cross(VT("/d<0>") (VAR("dvdd") / 2) 1 "rising" nil nil nil) - cross(VT("/divclk") (VAR("vdd") / 2) 1 "rising" nil nil nil)); (cross(VT("/divclk") (VAR("vdd") / 2) 1 "rising" nil nil nil) - cross(VT("/divclk") (VAR("vdd") / 2) 1 "rising" nil nil nil)); (cross(VT("/divclk") (VAR("vdd") / 2) 1 "rising" nil nil nil) - cross(VT("/XDUT/") (VAR("vdd") / 2) 1 "rising" nil nil nil)); (cross(VT("/divclk") (VAR("vdd") / 2) 1 "rising" nil nil nil) - cross(VT("/XDUT/INto1_0/temp_p0") (VAR("vdd") / 2) 1 "rising" nil nil nil)); (cross(VT("/d<0>") (VAR("dvdd") / 2) 1 "either" nil nil nil) - cross(VT("/divclk") (VAR("vdd") / 2) 1 "rising" nil nil nil)); nil; tset; (cross(VT("/d<0>") (VAR("dvdd") / 2) 2 "either" nil nil nil) - cross(VT("/divclk") (VAR("vdd") / 2) 3 "rising" nil nil nil)); (cross(VT("/d<0>") (VAR("dvdd") / 2) 3 "either" nil nil nil) - cross(VT("/divclk") (VAR("vdd") / 2) 1 "rising" nil nil nil)); (cross(VT("/XDUT/INto1_0/p0buf") (VAR("vdd") / 2) 2 "rising" nil nil nil) - cross(VT("/XDUT/INto1_0/temp_p0") (VAR("vdd") / 2) 1 "rising" nil nil nil)); (- (cross(VT("/XDUT/INto1_0/p0buf") (VAR("vdd") / 2) 2 "rising" nil nil nil) + cross(VT("/XDUT/INto1_0/temp_p0") (VAR("vdd") / 2) 1 "rising" nil nil nil))); (- (cross(VT("/XDUT/INto1_0/p0buf") (VAR("vdd") / 2) 1 "rising" nil nil nil) + cross(VT("/XDUT/INto1_0/temp_p0") (VAR("vdd") / 2) 1 "rising" nil nil nil))); (- (cross(VT("/XDUT/INto1_0/p0buf") (VAR("vdd") / 2) 1 "rising" nil nil nil) + cross(VT("/XDUT/INto1_0/temp_p0") (VAR("vdd") / 2) 1 "either" nil nil nil))); (((- cross(VT("/XDUT/INto1_0/p0buf") (VAR("vdd") / 2) 2 "rising" nil nil nil)) + cross(VT("/XDUT/INto1_0/temp_p0") (VAR("vdd") / 2) 1 "rising" nil nil nil))); ck2q_set
Global variables:
  pper = 400p
  pskew = 30p
  vdd = 0.9
  tsim = 10n
  dvdd = 0.8
  cslew = {Inclusion List}200p{Inclusion List}
  dslew = {Inclusion List}10p,50p{Inclusion List}
  delay = {From/To}Linear:1950p:2p:2050p{From/To}
Corners:
  FF: temperature=0; vdd=1.0; dvdd=0.88
  SS: temperature=125; vdd=0.8; dvdd=0.72
