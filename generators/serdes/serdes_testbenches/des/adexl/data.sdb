ADE simulation setup
Run mode: Single Run, Sweeps and Corners
Tests:
  serdes_testbenches:des:1: serdes_testbenches/des/schematic, simulator spectre
Global variables:
  pper = 200p
  pskew = 50p
  vdd = 1.0
  tsim = 10n
