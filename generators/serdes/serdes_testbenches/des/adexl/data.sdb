ADE simulation setup
Run mode: Single Run, Sweeps and Corners
Tests:
  serdes_testbenches:des:1: serdes_testbenches/des/config, simulator spectre
    Outputs: (cross(v("/clk_div" ?result "tran") (VAR("vdd") / 2) 1 "rising" nil nil) - cross(v("/XDUT/clk_int" ?result "tran") (VAR("vdd") * 0.5) 2 "rising" nil nil)); ck-dout delay
Global variables:
  pper = 400p
  pskew = 50p
  vdd = 0.9
  tsim = 8n
  c_load = {Inclusion List}0.31f, 0.53f, 0.97f, 1.85f, 3.61f, 7.14f, 14.2f, 28.31f{Inclusion List}
  cslew = {Inclusion List}1.3p, 2.9p, 6p, 12.2p, 24.7p, 49.7p, 99.7p, 199.6p{Inclusion List}
Corners:
  FF: temperature=0; vdd=1
  SS: temperature=125; vdd=0.8
