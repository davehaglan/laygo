ADE simulation setup
Run mode: Single Run, Sweeps and Corners
Tests:
  serdes_testbenches:serdes:1: serdes_testbenches/serdes/schematic, simulator spectre
    Outputs: (cross(VT("/clk_div") (VAR("vdd") / 2) 1 "rising" nil nil nil) - cross(VT("/dout<0>") (VAR("vdd") / 2) 1 "rising" nil nil nil)); (cross(VT("/divclk") (VAR("vdd") / 2) 1 "rising" nil nil nil) - cross(VT("/dout<0>") (VAR("vdd") / 2) 1 "rising" nil nil nil)); (cross(VT("/divclk") (VAR("dvdd") / 2) 1 "rising" nil nil nil) - cross(VT("/divclk") (VAR("vdd") / 2) 1 "rising" nil nil nil)); (cross(VT("/d<0>") (VAR("dvdd") / 2) 1 "rising" nil nil nil) - cross(VT("/divclk") (VAR("vdd") / 2) 1 "rising" nil nil nil)); (cross(VT("/divclk") (VAR("vdd") / 2) 1 "rising" nil nil nil) - cross(VT("/divclk") (VAR("vdd") / 2) 1 "rising" nil nil nil)); (cross(VT("/divclk") (VAR("vdd") / 2) 1 "rising" nil nil nil) - cross(VT("/XDUT/") (VAR("vdd") / 2) 1 "rising" nil nil nil)); (cross(VT("/divclk") (VAR("vdd") / 2) 1 "rising" nil nil nil) - cross(VT("/XDUT/INto1_0/temp_p0") (VAR("vdd") / 2) 1 "rising" nil nil nil)); (cross(VT("/d<0>") (VAR("dvdd") / 2) 1 "either" nil nil nil) - cross(VT("/divclk") (VAR("vdd") / 2) 1 "rising" nil nil nil)); nil; (cross(VT("/d<0>") (VAR("dvdd") / 2) 2 "either" nil nil nil) - cross(VT("/divclk") (VAR("vdd") / 2) 1 "rising" nil nil nil)); (cross(VT("/d<0>") (VAR("dvdd") / 2) 2 "either" nil nil nil) - cross(VT("/divclk") (VAR("vdd") / 2) 3 "rising" nil nil nil))
Global variables:
  pper = 70p
  pskew = 30p
  vdd = 0.9
  tsim = 10n
  delay = {From/To}Linear:0:3.5p:35p{From/To}
  dvdd = 0.8
Corners:
  FF: temperature=0; vdd=1.0; dvdd=0.88
  SS: temperature=125; vdd=0.8; dvdd=0.72
