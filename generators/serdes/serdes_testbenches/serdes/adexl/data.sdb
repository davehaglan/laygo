ADE simulation setup
Run mode: Single Run, Sweeps and Corners
Tests:
  serdes_testbenches:serdes:1: serdes_testbenches/serdes/config, simulator spectre
Global variables:
  pper = 70p
  pskew = 30p
  vdd = 0.9
  tsim = 10n
