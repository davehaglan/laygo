ADE simulation setup
Run mode: Single Run, Sweeps and Corners
Tests:
  adc_sar_testbenches:clktoq_tb:1: adc_sar_testbenches/clktoq_tb/config, simulator spectre
    Outputs: tf_1_0; trise; tfall; tckq_0_0; tckq_1_0; tckq_2_0; tckq_3_0; tckq_4_0; tckq_5_0; tckq_6_0; tckq_7_0; tf_0_0; tf_2_0; tf_3_0; tf_4_0; tf_5_0; tf_6_0; tf_7_0
Global variables:
  cl_data = {Inclusion List}1.7f, 3.2f, 6.3f, 12.5f, 24.9f, 49.6f, 70f{Inclusion List}
  cl = 10f
  duty = 0.125
  tper = 800p
  tr = 20p
  vdd = 720m
  l = 14n
  nfin = 4
Corners (nominal off):
  model folders: /proj/craft_gf/14LPP_XL/Models/Spectre/models
  func_0p88v_m40c_cmin (off): temperature=-40; vdd=0.88; LN14LPP_Spectre.lib[ff]
  func_0p88v_125c_cmax (off): temperature=125; vdd=0.88; LN14LPP_Spectre.lib[ss]
  func_0p72v_125c_cmin (off): temperature=125; vdd=0.72; LN14LPP_Spectre.lib[ff]
  func_0p88v_125c_cmin (off): temperature=125; vdd=0.88; LN14LPP_Spectre.lib[ff]
  func_0p72v_m40c_cmax: temperature=-40; vdd=0.72; LN14LPP_Spectre.lib[ss]
  func_0p88v_m40c_cmax (off): temperature=-40; vdd=0.88; LN14LPP_Spectre.lib[ss]
  func_0p72v_40c_cmin (off): temperature=-40; vdd=0.72; LN14LPP_Spectre.lib[ff]
  func_0p72v_125c_cmax (off): temperature=125; vdd=0.72; LN14LPP_Spectre.lib[ss]
