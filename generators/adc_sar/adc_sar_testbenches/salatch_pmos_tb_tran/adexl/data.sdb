ADE simulation setup
Run mode: Single Run, Sweeps and Corners
Tests:
  adc_sar_testbenches:salatch_tb_tran:1: adc_sar_testbenches/salatch_pmos_tb_tran/schematic, simulator spectre
    Outputs: tckq
Global variables:
  vdd = 0.9
  vamp = 10m
  vcm = 0.6
  vos = 0
  voscm = 0
  cload = 20f
  cint = 10f
  ctail = 10f
  costail = 10f
  tper = 1n
  tr = 20p
  tsim = 2.5n
  tstep = 1p
  csaload = 10f
