ADE simulation setup
Run mode: Single Run, Sweeps and Corners
Tests:
  adc_sar_testbenches:sourceFollower_tb:1: adc_sar_testbenches/sourceFollower_ac_tb/config, simulator spectre
Global variables:
  c_load = 20f
  ibias = 200u
  pper = 10n
  pskew_rst = 0
  pvicm = 0.5
  vdd = 0.9
  bypass = {Inclusion List}0,vdd{Inclusion List}
  fin = 100Meg
  pvidm = 0.2
  voff = 0
  vidm_ac = 1
  vidm_dc = 0
