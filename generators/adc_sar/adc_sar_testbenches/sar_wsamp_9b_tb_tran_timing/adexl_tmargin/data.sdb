ADE simulation setup
Run mode: Single Run, Sweeps and Corners
Tests:
  adc_sar_testbenches:sar_wsamp_9b_tb_tran_timing_rcx:1: adc_sar_testbenches/sar_wsamp_9b_tb_tran_timing/schematic, simulator spectre
Global variables:
  vdd = 900m
  pdelay = 2n/8
  pper = 2n
  pskew_rst = 0
  pvdd = 1.15
  pvicm = 150m
  pvidm = {Inclusion List}0{Inclusion List}{Inclusion List}1m{Inclusion List}{Inclusion List}10m{Inclusion List}
  pvref0 = 0.0
  pvref1 = 150m
  pvref2 = 300m
Corners:
  model folders: /tools/tstech16/CLN16FFC/PDK/models
  tt (off): temperature=25; vdd=0.9; toplevel.scs[top_tt]
  ssgnp072v125c (off): temperature=125; vdd=0.72; toplevel.scs[top_ss]
  ssgnp072v0c (off): temperature=0; vdd=0.72; toplevel.scs[top_ss]
  ffgnp0p88v125c (off): temperature=125; vdd=0.9; toplevel.scs[top_ff]
  ffgnp88v0c (off): temperature=0; vdd=0.9; toplevel.scs[top_ff]
  ssgnp09v125c (off): temperature=125; vdd=0.9; toplevel.scs[top_ss_gnp]
