ADE simulation setup
Run mode: Single Run, Sweeps and Corners
Tests:
  adc_sar_testbenches:sar_9b_tb_tran:1: adc_sar_testbenches/sar_wsamp_9b_tb_tran_timing/config, simulator spectre
    Outputs: /SAOP; /SAOM; /SAMPP; /ZMID<8:0>; /ZP<8:0>; /ZM<8:0>; /SAMP; /SARCLK; /SARCLKB
Global variables:
  pdelay = 1n
  pper = 2n
  pskew_rst = 0
  pvdd = 0.8
  pvicm = 150m
  pvidm = 150m
  pvref0 = 0.0
  pvref1 = 0.15
  pvref2 = 0.3
  vdd = 0.8
  l = 14m
  nfin = 4
