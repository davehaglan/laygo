ADE simulation setup
Run mode: Single Run, Sweeps and Corners
Tests:
  adc_sar_testbenches:sar_9b_tb_tran:1: adc_sar_testbenches/sar_wsamp_9b_tb_tran_timing/config, simulator spectre
Global variables:
  pdelay = 1n
  pper = 2n
  pskew_rst = 0
  pvdd = 1.15
  pvicm = 150m
  pvidm = {Inclusion List}0m{Inclusion List}{Inclusion List}1m{Inclusion List}{Inclusion List}10m{Inclusion List}
  pvref0 = 0.0
  pvref1 = 0.15
  pvref2 = 0.3
  vdd = 1.15
